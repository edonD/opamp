* High-Performance Op-Amp — Two-Stage + Class-AB Push-Pull Output
* ±15V dual supply, 600Ω load
* All component values optimized by DE. Do not hardcode values.
*
* Architecture:
*   Stage 1: PMOS diff pair + NMOS mirror load (high gain into high-Z)
*   Stage 2: Split complementary CS amps driving output gates
*     - M6a (NMOS CS): drives gp (PMOS output gate)
*     - M6b (PMOS CS): drives gn (NMOS output gate)
*   Output: Class-AB push-pull (M9 PMOS + M10 NMOS)

* ===== Supply =====
Vdd vdd 0 DC 15
Vss vss 0 DC -15

* ===== Input signal sources =====
Vdiff diff_sig 0 DC 0 AC 0.5
Vcm cm_sig 0 DC 0 AC 0

Einp inp 0 POLY(2) diff_sig 0 cm_sig 0 0 1 1
Einm inm 0 POLY(2) diff_sig 0 cm_sig 0 0 -1 1

* ===== First stage: PMOS diff pair + NMOS mirror =====
M1 d1 inp tail vdd PMOS W={W1}u L={L1}u
M2 d2 inm tail vdd PMOS W={W1}u L={L1}u
M3 d1 d1 vss vss NMOS W={W3}u L={L3}u
M4 d2 d1 vss vss NMOS W={W3}u L={L3}u
M5 tail pbias vdd vdd PMOS W={W5}u L={L5}u

* ===== Second stage A: NMOS CS drives PMOS output gate =====
M6a gp d2 vss vss NMOS W={W6a}u L={L6a}u
M8a gp pbias2 vdd vdd PMOS W={W8a}u L={L8a}u

* ===== Second stage B: PMOS CS drives NMOS output gate =====
M6b gn d2 vdd vdd PMOS W={W6b}u L={L6b}u
M8b gn nbias3 vss vss NMOS W={W8b}u L={L8b}u

* ===== Class-AB output stage =====
M9 out gp vdd vdd PMOS W={W9}u L={L9}u
M10 out gn vss vss NMOS W={W10}u L={L10}u

* ===== Miller compensation =====
* From output to stage 2A (gp node)
Cc1 gp comp1 {Cc1}
Rc1 comp1 out {Rc1}
* From output to stage 2B (gn node)
Cc2 gn comp2 {Cc2}
Rc2 comp2 out {Rc2}

* ===== Bias generation =====
* PMOS tail current for diff pair
Ibias1 pbias vss {Ibias1}
Mbias1 pbias pbias vdd vdd PMOS W={Wbias1}u L={Lbias1}u
* PMOS current source bias (for M8a load)
Ibias2 pbias2 vss {Ibias2}
Mbias2 pbias2 pbias2 vdd vdd PMOS W={Wbias2}u L={Lbias2}u
* NMOS current source bias (for M8b load)
Ibias3 vdd nbias3 {Ibias3}
Mbias3 nbias3 nbias3 vss vss NMOS W={Wbias3}u L={Lbias3}u

* ===== Load =====
RL out 0 600
CL out 0 100p

* ===== Models (Level 1 CMOS) =====
.model NMOS NMOS (LEVEL=1 VTO=0.7 KP=110u GAMMA=0.4 LAMBDA=0.04 PHI=0.65 TOX=9e-9)
.model PMOS PMOS (LEVEL=1 VTO=-0.7 KP=50u GAMMA=0.57 LAMBDA=0.05 PHI=0.65 TOX=9e-9)

* ===== Analysis =====
.control
* Operating point
op

* Bias checks
let vgs1 = v(inp) - v(tail)
let vds1 = v(d1) - v(tail)
let vgs5 = v(pbias) - v(vdd)
let vds5 = v(tail) - v(vdd)
let vgs6 = v(d2) - v(vss)
let vds6 = v(gp) - v(vss)
let vgs7 = v(gn) - v(vss)
let vds7 = v(out) - v(vss)

echo "RESULT_VGS1" $&vgs1
echo "RESULT_VDS1" $&vds1
echo "RESULT_VGS5" $&vgs5
echo "RESULT_VDS5" $&vds5
echo "RESULT_VGS6" $&vgs6
echo "RESULT_VDS6" $&vds6
echo "RESULT_VGS7" $&vgs7
echo "RESULT_VDS7" $&vds7

* Power
let pwr_mw = (abs(i(Vdd)) + abs(i(Vss))) * 15 * 1000
echo "RESULT_POWER_MW" $&pwr_mw

* AC analysis (differential)
ac dec 200 1 1G

meas ac dc_gain_db find vdb(out) at=10
meas ac gbw_hz when vdb(out)=0 fall=1
meas ac phase_at_gbw find vp(out) at=$&gbw_hz

let phase_margin = 180 + phase_at_gbw
echo "RESULT_PHASE_MARGIN" $&phase_margin

* Save DC gain for CMRR
set saved_dc_gain = "$&dc_gain_db"

* CMRR: switch to common-mode
alter @Vdiff[acmag] = 0
alter @Vcm[acmag] = 0.5
ac dec 200 1 1G
meas ac cm_gain_db find vdb(out) at=10
let cmrr_val = $saved_dc_gain - cm_gain_db
echo "RESULT_CMRR_DB" $&cmrr_val

* Restore differential for DC sweep
alter @Vdiff[acmag] = 0.5
alter @Vcm[acmag] = 0

* DC sweep for output swing
dc Vdiff -14 14 0.05
meas dc vout_min min v(out)
meas dc vout_max max v(out)
let swing = vout_max - vout_min
echo "RESULT_SWING" $&swing

echo "RESULT_DONE"
quit
.endc

.end
